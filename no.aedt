# Ansys Electronics Desktop project, version 2025.2
materials:
  vacuum: permittivity=1
  air
  saline: conductivity=1.5
  plexiglass
  Teflon
  platinum-iridium: conductivity=10000000
  Al-Extruded
surface materials:
  Steel-oxidised-surface

design HFSSDesign1 (HFSS, HFSS Terminal Network, model units mm)
geometry:
  Thicken1 [Teflon] = imported_body(C:\Users\nebula\Desktop\Assem3.STEP)
  Thicken11, Thicken12, Thicken13, Thicken2 [platinum-iridium] = imported_body(C:\Users\nebula\Desktop\Assem3.STEP)
  Thicken3 [Teflon] = imported_body(C:\Users\nebula\Desktop\Assem3.STEP)
  Thicken4 [platinum-iridium] = imported_body(C:\Users\nebula\Desktop\Assem3.STEP)
  Thicken5 [Teflon] = imported_body(C:\Users\nebula\Desktop\Assem3.STEP)
  Thicken6..Thicken9 [platinum-iridium] = imported_body(C:\Users\nebula\Desktop\Assem3.STEP)
  SplitLine2 [plexiglass] = imported_body(C:\Users\nebula\Desktop\Assem3.STEP)
  group lead = Thicken1, Thicken11, Thicken12, Thicken13, Thicken2..Thicken9
  group assembly = SplitLine2

design Maxwell3DDesign1 (Maxwell 3D, DC Conduction, model units mm)
geometry:
  SplitLine2 [plexiglass] = imported_body(C:\Users\nebula\Desktop\Assem3.STEP)
  NONE [saline] = imported_body(C:\Users\nebula\Desktop\saline.STEP)
  group assembly = SplitLine2
  group saline = NONE
boundaries and excitations:
  Voltage1: Voltage Faces=NONE.face(at (662.276, 932.22, 1397.06)) Voltage=0V
  Voltage2: Voltage Faces=NONE.face(at (662.427, 932.22, 1396.04)) Voltage=1V
mesh:
  ApplyCurvilinear1: Curvilinear Objects=NONE Apply
  initial mesh: GlobalSurfApproximation{CurvedSurfaceApproxChoice=UseSlider SliderMeshSettings=1}
setups:
  Setup1: DC Conduction MaximumPasses=10 MinimumPasses=2 MinimumConvergedPasses=1 PercentRefinement=10 PercentError=1 NonLinearResidual=0.001
field plots:
  J_Vector1: J in NONE on Setup1 : LastAdaptive
